| Teraspeed (R) Labs.
| http://www.teraspeedlabs.com
[IBIS Ver]   4.0
[Comment Char] |_char
[File Name]   si5340.ibs
[File Rev]   4.0
[Source]  Teraspeed (R) Labs.
[Date]   04-27-2016
[Notes]   Quality Check of this IBIS model: Model Passes IBIS Check
   Model parses into ICX IS. Simulation done with Hyperlynx.
   1. MIN TYP MAX information is based on Temperature, Voltage
   and process information.
   2. Package data gained using Tektronix IConnect Software.
   3. Die C
   4. Ramp Cautions should be ignored for LVDS, PECL and HCSL
   They are an artifact of the Parser
   5. Added in_ref_diff with 0.83 Vcm
[Disclaimer]
Silicon Labs Incorporated hereby grants the user of this IBIS
model a personal, non-exclusive, non-transferable license to use
this IBIS model under the following terms. Before using this
IBIS model, the user should read and agree with this license. If
the user does not accept these terms, the user should not use
the IBIS model and the IBIS model should be promptly returned to
Silicon Labs within 30 days. The user is granted this license
only to use the IBIS model and is not granted rights to sell,
load, rent, lease or license the IBIS model in whole or in part,
or in modified form to anyone. User may modify the IBIS model to
suit its specific applications, rights to derivative works and
such modifications shall belong and are hereby assigned to
Silicon Labs. This IBIS model is provided on an "as is" basis
and Silicon Labs makes absolutely no warranty with respect to
the IBIS model and the information contained herein. Silicon
Labs disclaims and customer waives all warranties, express or
implied, including warranties to merchantability or fitness for
a particular purpose. The entire risk as to quality and
performance is with the customer. Accordingly, in no event shall
the company be liable for any damages, whether in contract or
tort, including any lost profits or other incidental,
consequential, exemplary, or punitive damages arising out of the
use or application of the IBIS model provided in this package.
Further, Silicon Labs reserves the right to make changes without
notice to any product herein to improve reliability, function,
or design. Silicon Laboratories does not convey any license
under patent rights or any other intellectual property rights,
including those of third parties. Silicon Labs is not obligated
to provide maintenance or support for the licensed IBIS model.
[Copyright]  (c) 2016, Silicon Labs, Inc.
[Component]   SI5340
[Manufacturer] Silicon Labs
[Package]
| Data Sheet: Rev. 0.9, 7//14
| 7mm x 7mm, 44 lead QFN
| variable   typ   min   max
R_pkg  1.000E-02   1.000E-02   1.000E-02
L_pkg  2.744E-09   1.680E-09   3.630E-09
C_pkg  8.903E-13   7.130E-13   1.038E-12
[Pin] signal_name  model_name  R_pin  L_pin C_pin
1   IN1   in_ref   1.000E-02   3.630E-09   1.038E-12
2   *IN1   in_ref   1.000E-02   3.240E-09   9.730E-13
3   IN_SEL0   clk_sel   1.000E-02   2.850E-09   9.080E-13
4   XGND   GND   1.000E-02   2.460E-09   8.430E-13
5   XA   term   1.000E-02   2.070E-09   7.780E-13
6   XB   term   1.000E-02   1.680E-09   7.130E-13
7   XGND   GND   1.000E-02   2.070E-09   7.780E-13
8   VDDA   POWER   1.000E-02   2.460E-09   8.430E-13
9   VDDA   POWER   1.000E-02   2.850E-09   9.080E-13
10   IN2   in_ref   1.000E-02   3.240E-09   9.730E-13
11   *IN2   in_ref   1.000E-02   3.630E-09   1.038E-12
12   *OE   in_pd   1.000E-02   3.630E-09   1.038E-12
13   SDA/SDIO   sda_sdio   1.000E-02   3.240E-09   9.730E-13
14   SCLK   sclk   1.000E-02   2.850E-09   9.080E-13
15   A1/SDO   a1_sdo   1.000E-02   2.460E-09   8.430E-13
16   A0/*CS   in_pu   1.000E-02   2.070E-09   7.780E-13
17   *RST   in_pu   1.000E-02   1.680E-09   7.130E-13
18   VDDO0   POWER   1.000E-02   2.070E-09   7.780E-13
19   *OUT0   OUT0   1.000E-02   2.460E-09   8.430E-13
20   OUT0   OUT0   1.000E-02   2.850E-09   9.080E-13
21   VDD   POWER   1.000E-02   3.240E-09   9.730E-13
22   RSVD   NC   1.000E-02   3.630E-09   1.038E-12
23   VDDO1   POWER   1.000E-02   3.630E-09   1.038E-12
24   *OUT1   OUT1   1.000E-02   3.240E-09   9.730E-13
25   OUT1   OUT1   1.000E-02   2.850E-09   9.080E-13
26   VDDS   POWER   1.000E-02   2.460E-09   8.430E-13
27   *LOL   lol   1.000E-02   2.070E-09   7.780E-13
28   *LOSXAXB   lol   1.000E-02   1.680E-09   7.130E-13
29   VDDO2   POWER   1.000E-02   2.070E-09   7.780E-13
30   *OUT2   OUT2   1.000E-02   2.460E-09   8.430E-13
31   OUT2   OUT2   1.000E-02   2.850E-09   9.080E-13
32   VDD   POWER   1.000E-02   3.240E-09   9.730E-13
33   *INTR   intr   1.000E-02   3.630E-09   1.038E-12
34   VDDO3   POWER   1.000E-02   3.630E-09   1.038E-12
35   *OUT3   OUT3   1.000E-02   3.240E-09   9.730E-13
36   OUT3   OUT3   1.000E-02   2.850E-09   9.080E-13
37   IN_SEL1   clk_sel   1.000E-02   2.460E-09   8.430E-13
38   I2C_SEL   in_pu   1.000E-02   2.070E-09   7.780E-13
39   VDD   POWER   1.000E-02   1.680E-09   7.130E-13
40   VDD   POWER   1.000E-02   2.070E-09   7.780E-13
41   IN3/FB_IN   in_ref   1.000E-02   2.460E-09   8.430E-13
42   *IN3/*FB_IN in_ref   1.000E-02   2.850E-09   9.080E-13
43   IN0   in_ref   1.000E-02   3.240E-09   9.730E-13
44   *IN0   in_ref   1.000E-02   3.630E-09   1.038E-12
45   EPAD   GND   0.000E+00   0.000E+00   0.000E+00
[Diff Pin] inv_pin vdiff tdelay_typ tdelay_min tdelay_max
|Comment out selected CLK input diff pins for SE input mode.
43  44   200mV  NA   NA   NA  | IN0
1   2   200mV  NA   NA   NA  | IN1
10  11   200mV  NA   NA   NA  | IN2
41  42   200mV  NA   NA   NA  | IN3
|Comment out select diff pins for CMOS output mode.
20  19   NA   NA   NA   NA  | OUT0
25  24   NA   NA   NA   NA  | OUT1
31  30   NA   NA   NA   NA  | OUT2
36  35   NA   NA   NA   NA  | OUT3
[Model Selector] in_ref
in_ref_se   single ended input with pulldown
in_ref_diff  differential input with 0.83Vcm
[Model Selector] a1_sdo
a1_3.3v   i2c addr in,vdd=3.3v
a1_1.8v   i2c addr in,vdd=1.8v
sdo_3.3v   spi data out,vdd=3.3v
sdo_1.8v   spi data out,vdd=1.8v
[Model Selector] clk_sel
a1_3.3v   clk source sel,vdd=3.3v
a1_1.8v   clk source sel,vdd=1.8v
[Model Selector] in_pd
pd_3.3v   input w/int pd,vdd=3.3v
pd_1.8v   input w/int pd,vdd=1.8v
[Model Selector] in_pu
pu_3.3v   input w/int pu,vdd=3.3v
pu_1.8v   input w/int pu,vdd=1.8v
[Model Selector] intr
intr_3.3v  open drain out,vdd=3.3v
intr_1.8v  open drain out,vdd=1.8v
[Model Selector] lol
lol_3.3v   status out,vdd=3.3v
lol_1.8v   status out,vdd=1.8v
[Model Selector] sclk
sclk_3.3v  spi/i2c clk in,vdd=3.3v
sclk_1.8v  spi/i2c clk in,vdd=1.8v
[Model Selector] sda_sdio
sda_3.3v   i2c data io,vdd=3.3v
sda_1.8v   i2c data io,vdd=1.8v
sdio_3.3v   spi data io,vdd=3.3v
sdio_1.8v   spi data io,vdd=1.8v
[Model Selector] OUT0
cmos_38ohm_3.3v   cmos,Zout=38ohm,vddo0=3.3v
cmos_30ohm_3.3v   cmos,Zout=30ohm,vddo0=3.3v
cmos_22ohm_3.3v   cmos,Zout=22ohm,vddo0=3.3v
cmos_43ohm_2.5v   cmos,Zout=43ohm,vddo0=2.5v
cmos_35ohm_2.5v   cmos,Zout=35ohm,vddo0=2.5v
cmos_24ohm_2.5v   cmos,Zout=24ohm,vddo0=2.5v
cmos_31ohm_1.8v   cmos,Zout=31ohm,vddo0=1.8v
hcsl_3.3v   hcsl out,vddo=3.3v
hcsl_2.5v   hcsl out,vddo=2.5v
hcsl_1.8v   hcsl out,vddo=1.8v
lvds_.4v_2.0vcm_3.3v   0.4v,2.0vcm,vddo0=3.3v
lvds_.4v_1.2vcm_2.5v   0.4v,1.2vcm,vddo0=2.5v
lvds_.4v_0.8vcm_1.8v   0.4v,0.9vcm,vddo0=1.8v
pecl_.8v_2.0vcm_3.3v   0.8v,2.0vcm,vddo0=3.3v
pecl_.8v_1.2vcm_2.5v   0.8v,1.2vcm,vddo0=2.5v
[Model Selector] OUT1
cmos_38ohm_3.3v   cmos,Zout=38ohm,vddo0=3.3v
cmos_30ohm_3.3v   cmos,Zout=30ohm,vddo0=3.3v
cmos_22ohm_3.3v   cmos,Zout=22ohm,vddo0=3.3v
cmos_43ohm_2.5v   cmos,Zout=43ohm,vddo0=2.5v
cmos_35ohm_2.5v   cmos,Zout=35ohm,vddo0=2.5v
cmos_24ohm_2.5v   cmos,Zout=24ohm,vddo0=2.5v
cmos_31ohm_1.8v   cmos,Zout=31ohm,vddo0=1.8v
hcsl_3.3v   hcsl out,vddo=3.3v
hcsl_2.5v   hcsl out,vddo=2.5v
hcsl_1.8v   hcsl out,vddo=1.8v
lvds_.4v_2.0vcm_3.3v   0.4v,2.0vcm,vddo0=3.3v
lvds_.4v_1.2vcm_2.5v   0.4v,1.2vcm,vddo0=2.5v
lvds_.4v_0.8vcm_1.8v   0.4v,0.9vcm,vddo0=1.8v
pecl_.8v_2.0vcm_3.3v   0.8v,2.0vcm,vddo0=3.3v
pecl_.8v_1.2vcm_2.5v   0.8v,1.2vcm,vddo0=2.5v
[Model Selector] OUT2
cmos_38ohm_3.3v   cmos,Zout=38ohm,vddo0=3.3v
cmos_30ohm_3.3v   cmos,Zout=30ohm,vddo0=3.3v
cmos_22ohm_3.3v   cmos,Zout=22ohm,vddo0=3.3v
cmos_43ohm_2.5v   cmos,Zout=43ohm,vddo0=2.5v
cmos_35ohm_2.5v   cmos,Zout=35ohm,vddo0=2.5v
cmos_24ohm_2.5v   cmos,Zout=24ohm,vddo0=2.5v
cmos_31ohm_1.8v   cmos,Zout=31ohm,vddo0=1.8v
hcsl_3.3v   hcsl out,vddo=3.3v
hcsl_2.5v   hcsl out,vddo=2.5v
hcsl_1.8v   hcsl out,vddo=1.8v
lvds_.4v_2.0vcm_3.3v   0.4v,2.0vcm,vddo0=3.3v
lvds_.4v_1.2vcm_2.5v   0.4v,1.2vcm,vddo0=2.5v
lvds_.4v_0.8vcm_1.8v   0.4v,0.9vcm,vddo0=1.8v
pecl_.8v_2.0vcm_3.3v   0.8v,2.0vcm,vddo0=3.3v
pecl_.8v_1.2vcm_2.5v   0.8v,1.2vcm,vddo0=2.5v
[Model Selector] OUT3
cmos_38ohm_3.3v   cmos,Zout=38ohm,vddo0=3.3v
cmos_30ohm_3.3v   cmos,Zout=30ohm,vddo0=3.3v
cmos_22ohm_3.3v   cmos,Zout=22ohm,vddo0=3.3v
cmos_43ohm_2.5v   cmos,Zout=43ohm,vddo0=2.5v
cmos_35ohm_2.5v   cmos,Zout=35ohm,vddo0=2.5v
cmos_24ohm_2.5v   cmos,Zout=24ohm,vddo0=2.5v
cmos_31ohm_1.8v   cmos,Zout=31ohm,vddo0=1.8v
hcsl_3.3v   hcsl out,vddo=3.3v
hcsl_2.5v   hcsl out,vddo=2.5v
hcsl_1.8v   hcsl out,vddo=1.8v
lvds_.4v_2.0vcm_3.3v   0.4v,2.0vcm,vddo0=3.3v
lvds_.4v_1.2vcm_2.5v   0.4v,1.2vcm,vddo0=2.5v
lvds_.4v_0.8vcm_1.8v   0.4v,0.9vcm,vddo0=1.8v
pecl_.8v_2.0vcm_3.3v   0.8v,2.0vcm,vddo0=3.3v
pecl_.8v_1.2vcm_2.5v   0.8v,1.2vcm,vddo0=2.5v
[Model] term
Model_type Terminator
C_comp  0pF 0pF 0pF
| variable typ   min   max
[Voltage Range]   3.30000V  3.13500V  3.46500V
[POWER Clamp Reference]  3.30000V  3.13500V  3.46500V
[GND Clamp Reference]   0.00000V  0.00000V  0.00000V
[Temperature Range]   25   85   -40
| Models and submodels in the file (36): in_ref_diff (Input), in_ref_se (Input), pd_1.8v (Input), pd_3.3v (Input), pu_1.8v (Input), pu_3.3v (Input), a1_1.8v (Input), a1_3.3v (Input), sclk_1.8v (Input), sclk_3.3v (Input), cmos_31ohm_1.8v (3-state), cmos_24ohm_2.5v (3-state), cmos_35ohm_2.5v (3-state), cmos_43ohm_2.5v (3-state), cmos_22ohm_3.3v (3-state), cmos_30ohm_3.3v (3-state), cmos_38ohm_3.3v (3-state), hcsl_1.8v (3-state), hcsl_2.5v (3-state), hcsl_3.3v (3-state), intr_1.8v (Open_drain), intr_3.3v (Open_drain), lol_1.8v (3-state), lol_3.3v (Output), lvds_.4v_0.8vcm_1.8v (3-state), lvds_.4v_1.2vcm_2.5v (3-state), lvds_.4v_2.0vcm_3.3v (3-state), pecl_.8v_1.2vcm_2.5v (3-state), pecl_.8v_2.0vcm_3.3v (3-state), sda_1.8v (I/O_open_drain), sda_3.3v (I/O_open_drain), sdio_1.8v (I/O), sdio_3.3v (I/O), sdo_1.8v (3-state), sdo_3.3v (3-state), term (Terminator)
